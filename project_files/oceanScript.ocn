ocnWaveformTool( 'wavescan )
simulator( 'spectre )
design(	 "/home/vlsi4/cadence/simulation/dffr/spectre/schematic/netlist/netlist")
resultsDir( "/home/vlsi4/cadence/simulation/dffr/spectre/schematic" )
modelFile(
    '("/usr/ee424/ami06P.m" "")
    '("/usr/ee424/ami06N.m" "")
)
stimulusFile( ?xlate nil
    "/home/vlsi4/cadence/simulation/dffr/spectre/schematic/netlist/stimuli/stim1.txt"
)
analysis('tran ?stop "50n"  )
envOption(
	'spp  "Y"
)
temp( 27 )
run()
selectResult( 'tran )
plot(getData("/QB") getData("/Q") getData("/CLK") getData("/D") getData("/R") )
