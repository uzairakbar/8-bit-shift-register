// Design: Counter/counter
simulator lang=spectre
global 0 vdd!
include "/usr/Cadence/tools/dfII/samples/artist/ahdlLib/quantity.spectre"
include "/usr/ee424/ami06N.m"
include "/usr/ee424/ami06P.m"

// Counter/dffr/schematic
subckt dffr CLK D Q QB R
    N19 (net34 net70 net22 0) ami06N w=1.5u l=600n m=1 region=sat
    N17 (net62 net70 net58 0) ami06N w=1.5u l=600n m=1 region=sat
    N18 (net62 net66 net50 0) ami06N w=1.5u l=600n m=1 region=sat
    N20 (net34 net106 net30 0) ami06N w=1.5u l=600n m=1 region=sat
    N16 (Q QB 0 0) ami06N w=1.5u l=600n m=1 region=sat
    N15 (QB net34 0 0) ami06N w=1.5u l=600n m=1 region=sat
    N14 (net96 net34 0 0) ami06N w=1.5u l=600n m=1 region=sat
    N13 (net22 R 0 0) ami06N w=1.5u l=600n m=1 region=sat
    N12 (net22 net96 0 0) ami06N w=1.5u l=600n m=1 region=sat
    N10 (net30 net66 0 0) ami06N w=1.5u l=600n m=1 region=sat
    N8 (net106 net42 0 0) ami06N w=1.5u l=600n m=1 region=sat
    N7 (net42 R 0 0) ami06N w=1.5u l=600n m=1 region=sat
    N6 (net42 net62 0 0) ami06N w=1.5u l=600n m=1 region=sat
    N5 (net50 net42 0 0) ami06N w=1.5u l=600n m=1 region=sat
    N3 (net58 D 0 0) ami06N w=1.5u l=600n m=1 region=sat
    N1 (net66 net70 0 0) ami06N w=1.5u l=600n m=1 region=sat
    N0 (net70 CLK 0 0) ami06N w=1.5u l=600n m=1 region=sat
    P22 (net0197 R net91 vdd!) ami06P w=1.5u l=600n m=1 region=sat
    P19 (net42 R net111 vdd!) ami06P w=1.5u l=600n m=1 region=sat
    P17 (net62 net66 net127 vdd!) ami06P w=1.5u l=600n m=1 region=sat
    P20 (net34 net70 net99 vdd!) ami06P w=1.5u l=600n m=1 region=sat
    P21 (net34 net66 net0197 vdd!) ami06P w=1.5u l=600n m=1 region=sat
    P18 (net62 net70 net119 vdd!) ami06P w=1.5u l=600n m=1 region=sat
    P16 (Q QB vdd! vdd!) ami06P w=1.5u l=600n m=1 region=sat
    P15 (QB net34 vdd! vdd!) ami06P w=1.5u l=600n m=1 region=sat
    P14 (net96 net34 vdd! vdd!) ami06P w=1.5u l=600n m=1 region=sat
    P11 (net91 net96 vdd! vdd!) ami06P w=1.5u l=600n m=1 region=sat
    P9 (net99 net106 vdd! vdd!) ami06P w=1.5u l=600n m=1 region=sat
    P8 (net106 net42 vdd! vdd!) ami06P w=1.5u l=600n m=1 region=sat
    P6 (net111 net62 vdd! vdd!) ami06P w=1.5u l=600n m=1 region=sat
    P4 (net119 net42 vdd! vdd!) ami06P w=1.5u l=600n m=1 region=sat
    P2 (net127 D vdd! vdd!) ami06P w=1.5u l=600n m=1 region=sat
    P1 (net66 net70 vdd! vdd!) ami06P w=1.5u l=600n m=1 region=sat
    P0 (net70 CLK vdd! vdd!) ami06P w=1.5u l=600n m=1 region=sat
ends dffr

// Counter/counter/schematic
I3 (Clk net6 Y2 net6 R) dffr
I1 (net6 net11 Y1 net11 R) dffr
I0 (net11 net16 Y0 net16 R) dffr
include "/home/vlsi4/groupwork/counter/spectre/schematic/netlist/stimuli/counter.txt"
simulatorOptions options temp=27
tran tran stop=200n
